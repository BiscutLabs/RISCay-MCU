* SPDX-License-Identifier: Apache-2.0
* RISCay-MCU GF180 low-power oscillator SCHEMATIC CANDIDATE, not qualified IP.
* Derived from Tim Edwards/Efabless sky130_ef_ip__rc_osc_500k architecture.
* See NOTICE.md and upstream/LICENSE. Substantial modifications: GF180 3.3V,
* beta-multiplier bias, POR-assisted startup, configurable ring, stacked buffer.
* Generated by design.py. No ideal current sources, resistors or timing caps.
* rst_n must stay LOW during power ramp and >= 5 ms after supply is valid.
* Reset actively starts the bias; it is NOT a low-current shutdown control.
* Clock output is forced LOW in reset. Supply is the only power-off control.
.subckt riscay_lf_osc_gf180 vdd vss rst_n clk
Xreset_p rst rst_n vdd vdd pmos_3p3 w=1u l=1u ad=0.5p as=0.5p pd=3u ps=3u
Xreset_n rst rst_n vss vss nmos_3p3 w=1u l=1u ad=0.5p as=0.5p pd=3u ps=3u
* Self-biased current reference. N ratio 4:1, matched P mirror.
Xref_p nbias pbias vdd vdd pmos_3p3 w=1u l=2u ad=0.5p as=0.5p pd=3u ps=3u
Xref_pd pbias pbias vdd vdd pmos_3p3 w=1u l=2u ad=0.5p as=0.5p pd=3u ps=3u
Xref_nd nbias nbias vss vss nmos_3p3 w=1u l=2u ad=0.5p as=0.5p pd=3u ps=3u
Xref_n4 pbias nbias rtop vss nmos_3p3 w=4u l=2u ad=2p as=2p pd=9u ps=9u
XR0 rtop res1 vss ppolyf_u_3k r_width=1u r_length=9543.6u
XR1 res1 res2 vss ppolyf_u_3k r_width=1u r_length=9543.6u
XR2 res2 res3 vss ppolyf_u_3k r_width=1u r_length=9543.6u
XR3 res3 res4 vss ppolyf_u_3k r_width=1u r_length=9543.6u
XR4 res4 res5 vss ppolyf_u_3k r_width=1u r_length=9543.6u
XR5 res5 res6 vss ppolyf_u_3k r_width=1u r_length=9543.6u
XR6 res6 res7 vss ppolyf_u_3k r_width=1u r_length=9543.6u
XR7 res7 res8 vss ppolyf_u_3k r_width=1u r_length=9543.6u
XR8 res8 res9 vss ppolyf_u_3k r_width=1u r_length=9543.6u
XR9 res9 vss vss ppolyf_u_3k r_width=1u r_length=9543.6u
* POR removes the beta multiplier's zero-current equilibrium.
Xstartup pbias rst vss vss nmos_3p3 w=0.22u l=10u ad=0.11p as=0.11p pd=1.44u ps=1.44u
* Current-starved ring: explicit slow timing nodes, common bias.
Xps0 ps0 pbias vdd vdd pmos_3p3 w=1u l=2u ad=0.5p as=0.5p pd=3u ps=3u
Xp0 r0 r6 ps0 vdd pmos_3p3 w=1u l=1u ad=0.5p as=0.5p pd=3u ps=3u
Xn0 r0 r6 ns0 vss nmos_3p3 w=1u l=1u ad=0.5p as=0.5p pd=3u ps=3u
Xns0 ns0 nbias vss vss nmos_3p3 w=1u l=2u ad=0.5p as=0.5p pd=3u ps=3u
Xtiming0 vss r0 vss vss nmos_3p3 w=10u l=10u ad=5p as=5p pd=21u ps=21u
Xps1 ps1 pbias vdd vdd pmos_3p3 w=1u l=2u ad=0.5p as=0.5p pd=3u ps=3u
Xp1 r1 r0 ps1 vdd pmos_3p3 w=1u l=1u ad=0.5p as=0.5p pd=3u ps=3u
Xn1 r1 r0 ns1 vss nmos_3p3 w=1u l=1u ad=0.5p as=0.5p pd=3u ps=3u
Xns1 ns1 nbias vss vss nmos_3p3 w=1u l=2u ad=0.5p as=0.5p pd=3u ps=3u
Xtiming1 vss r1 vss vss nmos_3p3 w=10u l=10u ad=5p as=5p pd=21u ps=21u
Xps2 ps2 pbias vdd vdd pmos_3p3 w=1u l=2u ad=0.5p as=0.5p pd=3u ps=3u
Xp2 r2 r1 ps2 vdd pmos_3p3 w=1u l=1u ad=0.5p as=0.5p pd=3u ps=3u
Xn2 r2 r1 ns2 vss nmos_3p3 w=1u l=1u ad=0.5p as=0.5p pd=3u ps=3u
Xns2 ns2 nbias vss vss nmos_3p3 w=1u l=2u ad=0.5p as=0.5p pd=3u ps=3u
Xtiming2 vss r2 vss vss nmos_3p3 w=10u l=10u ad=5p as=5p pd=21u ps=21u
Xps3 ps3 pbias vdd vdd pmos_3p3 w=1u l=2u ad=0.5p as=0.5p pd=3u ps=3u
Xp3 r3 r2 ps3 vdd pmos_3p3 w=1u l=1u ad=0.5p as=0.5p pd=3u ps=3u
Xn3 r3 r2 ns3 vss nmos_3p3 w=1u l=1u ad=0.5p as=0.5p pd=3u ps=3u
Xns3 ns3 nbias vss vss nmos_3p3 w=1u l=2u ad=0.5p as=0.5p pd=3u ps=3u
Xtiming3 vss r3 vss vss nmos_3p3 w=10u l=10u ad=5p as=5p pd=21u ps=21u
Xps4 ps4 pbias vdd vdd pmos_3p3 w=1u l=2u ad=0.5p as=0.5p pd=3u ps=3u
Xp4 r4 r3 ps4 vdd pmos_3p3 w=1u l=1u ad=0.5p as=0.5p pd=3u ps=3u
Xn4 r4 r3 ns4 vss nmos_3p3 w=1u l=1u ad=0.5p as=0.5p pd=3u ps=3u
Xns4 ns4 nbias vss vss nmos_3p3 w=1u l=2u ad=0.5p as=0.5p pd=3u ps=3u
Xtiming4 vss r4 vss vss nmos_3p3 w=10u l=10u ad=5p as=5p pd=21u ps=21u
Xps5 ps5 pbias vdd vdd pmos_3p3 w=1u l=2u ad=0.5p as=0.5p pd=3u ps=3u
Xp5 r5 r4 ps5 vdd pmos_3p3 w=1u l=1u ad=0.5p as=0.5p pd=3u ps=3u
Xn5 r5 r4 ns5 vss nmos_3p3 w=1u l=1u ad=0.5p as=0.5p pd=3u ps=3u
Xns5 ns5 nbias vss vss nmos_3p3 w=1u l=2u ad=0.5p as=0.5p pd=3u ps=3u
Xtiming5 vss r5 vss vss nmos_3p3 w=10u l=10u ad=5p as=5p pd=21u ps=21u
Xps6 ps6 pbias vdd vdd pmos_3p3 w=1u l=2u ad=0.5p as=0.5p pd=3u ps=3u
Xp6 r6 r5 ps6 vdd pmos_3p3 w=1u l=1u ad=0.5p as=0.5p pd=3u ps=3u
Xn6 r6 r5 ns6 vss nmos_3p3 w=1u l=1u ad=0.5p as=0.5p pd=3u ps=3u
Xns6 ns6 nbias vss vss nmos_3p3 w=1u l=2u ad=0.5p as=0.5p pd=3u ps=3u
Xtiming6 vss r6 vss vss nmos_3p3 w=10u l=10u ad=5p as=5p pd=21u ps=21u
Xpark r0 rst vss vss nmos_3p3 w=1u l=1u ad=0.5p as=0.5p pd=3u ps=3u
* Weak stacked inverter reduces crowbar current from slow ring edges.
Xbufp0 q r0 bp1 vdd pmos_3p3 w=0.44u l=50u ad=0.22p as=0.22p pd=1.88u ps=1.88u
Xbufn0 q r0 bn1 vss nmos_3p3 w=0.22u l=50u ad=0.11p as=0.11p pd=1.44u ps=1.44u
Xbufp1 bp1 r0 bp2 vdd pmos_3p3 w=0.44u l=50u ad=0.22p as=0.22p pd=1.88u ps=1.88u
Xbufn1 bn1 r0 bn2 vss nmos_3p3 w=0.22u l=50u ad=0.11p as=0.11p pd=1.44u ps=1.44u
Xbufp2 bp2 r0 bp3 vdd pmos_3p3 w=0.44u l=50u ad=0.22p as=0.22p pd=1.88u ps=1.88u
Xbufn2 bn2 r0 bn3 vss nmos_3p3 w=0.22u l=50u ad=0.11p as=0.11p pd=1.44u ps=1.44u
Xbufp3 bp3 r0 bp4 vdd pmos_3p3 w=0.44u l=50u ad=0.22p as=0.22p pd=1.88u ps=1.88u
Xbufn3 bn3 r0 bn4 vss nmos_3p3 w=0.22u l=50u ad=0.11p as=0.11p pd=1.44u ps=1.44u
Xbufp4 bp4 r0 bp5 vdd pmos_3p3 w=0.44u l=50u ad=0.22p as=0.22p pd=1.88u ps=1.88u
Xbufn4 bn4 r0 bn5 vss nmos_3p3 w=0.22u l=50u ad=0.11p as=0.11p pd=1.44u ps=1.44u
Xbufp5 bp5 r0 bp6 vdd pmos_3p3 w=0.44u l=50u ad=0.22p as=0.22p pd=1.88u ps=1.88u
Xbufn5 bn5 r0 bn6 vss nmos_3p3 w=0.22u l=50u ad=0.11p as=0.11p pd=1.44u ps=1.44u
Xbufp6 bp6 r0 bp7 vdd pmos_3p3 w=0.44u l=50u ad=0.22p as=0.22p pd=1.88u ps=1.88u
Xbufn6 bn6 r0 bn7 vss nmos_3p3 w=0.22u l=50u ad=0.11p as=0.11p pd=1.44u ps=1.44u
Xbufp7 bp7 r0 vdd vdd pmos_3p3 w=0.44u l=50u ad=0.22p as=0.22p pd=1.88u ps=1.88u
Xbufn7 bn7 r0 vss vss nmos_3p3 w=0.22u l=50u ad=0.11p as=0.11p pd=1.44u ps=1.44u
* Intermediate buffer sharpens edges before the stronger clock driver.
Xmidp mid q vdd vdd pmos_3p3 w=0.44u l=5u ad=0.22p as=0.22p pd=1.88u ps=1.88u
Xmidn mid q vss vss nmos_3p3 w=0.22u l=5u ad=0.11p as=0.11p pd=1.44u ps=1.44u
Xgatep1 gated mid vdd vdd pmos_3p3 w=1u l=0.28u ad=0.5p as=0.5p pd=3u ps=3u
Xgatep2 gated rst_n vdd vdd pmos_3p3 w=1u l=0.28u ad=0.5p as=0.5p pd=3u ps=3u
Xgaten1 gated mid gn vss nmos_3p3 w=1u l=0.28u ad=0.5p as=0.5p pd=3u ps=3u
Xgaten2 gn rst_n vss vss nmos_3p3 w=1u l=0.28u ad=0.5p as=0.5p pd=3u ps=3u
Xoutp clk gated vdd vdd pmos_3p3 w=2u l=0.28u ad=1p as=1p pd=5u ps=5u
Xoutn clk gated vss vss nmos_3p3 w=1u l=0.28u ad=0.5p as=0.5p pd=3u ps=3u
.ends riscay_lf_osc_gf180
